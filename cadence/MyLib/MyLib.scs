**MyLib
simulator lang=spice

.INC 'PTMNC.scs'

simulator lang=spectre
